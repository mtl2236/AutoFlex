// Design: CNT_CMOS/ADDHX1
simulator lang=spectre
//global 0 VDD VSS
//include "/simulation/tianliang/test/gpdk045_v_6_0/gpdk045/../models/spectre/gpdk045.scs" section=mc

// CNT_CMOS/ADDHX1/schematic
subckt ADDHX1 VSS VDD A B CO S
mp2 (n3 n0 VDD) CNT_CDF l=0.6 w=5 MU=55 COX=110e-09 COL=0 CGSD=0 COLGSD=0 CSD=0 VTO=-0.7 FLG_SPLT=1 FINGER=1 sdW=10 gsdEnc=1 gcntEnc=3 TEMP=300 LAMBDA=0.005 VSS=0.18 GAMMA=0.35 IOFF=0 MM=1.65 AA=1 SLOPE=10 VAA=1 RCS=500 RCD=500 FLG_FLD=0 RFS=1 RFD=1 RFG=1 typep=-1
mp1 (n1 B VDD) CNT_CDF l=0.6 w=5 MU=55 COX=110e-09 COL=0 CGSD=0 COLGSD=0 CSD=0 VTO=-0.7 FLG_SPLT=1 FINGER=1 sdW=10 gsdEnc=1 gcntEnc=3 TEMP=300 LAMBDA=0.005 VSS=0.18 GAMMA=0.35 IOFF=0 MM=1.65 AA=1 SLOPE=10 VAA=1 RCS=500 RCD=500 FLG_FLD=0 RFS=1 RFD=1 RFG=1 typep=-1
mp0 (n0 A VDD) CNT_CDF l=0.6 w=5 MU=55 COX=110e-09 COL=0 CGSD=0 COLGSD=0 CSD=0 VTO=-0.7 FLG_SPLT=1 FINGER=1 sdW=10 gsdEnc=1 gcntEnc=3 TEMP=300 LAMBDA=0.005 VSS=0.18 GAMMA=0.35 IOFF=0 MM=1.65 AA=1 SLOPE=10 VAA=1 RCS=500 RCD=500 FLG_FLD=0 RFS=1 RFD=1 RFG=1 typep=-1
mp8 (CO COb VDD) CNT_CDF l=0.6 w=5 MU=55 COX=110e-09 COL=0 CGSD=0 COLGSD=0 CSD=0 VTO=-0.7 FLG_SPLT=1 FINGER=1 sdW=10 gsdEnc=1 gcntEnc=3 TEMP=300 LAMBDA=0.005 VSS=0.18 GAMMA=0.35 IOFF=0 MM=1.65 AA=1 SLOPE=10 VAA=1 RCS=500 RCD=500 FLG_FLD=0 RFS=1 RFD=1 RFG=1 typep=-1
mp5 (S Sb VDD) CNT_CDF l=0.6 w=5 MU=55 COX=110e-09 COL=0 CGSD=0 COLGSD=0 CSD=0 VTO=-0.7 FLG_SPLT=1 FINGER=1 sdW=10 gsdEnc=1 gcntEnc=3 TEMP=300 LAMBDA=0.005 VSS=0.18 GAMMA=0.35 IOFF=0 MM=1.65 AA=1 SLOPE=10 VAA=1 RCS=500 RCD=500 FLG_FLD=0 RFS=1 RFD=1 RFG=1 typep=-1
mp7 (COb B VDD) CNT_CDF l=0.6 w=5 MU=55 COX=110e-09 COL=0 CGSD=0 COLGSD=0 CSD=0 VTO=-0.7 FLG_SPLT=1 FINGER=1 sdW=10 gsdEnc=1 gcntEnc=3 TEMP=300 LAMBDA=0.005 VSS=0.18 GAMMA=0.35 IOFF=0 MM=1.65 AA=1 SLOPE=10 VAA=1 RCS=500 RCD=500 FLG_FLD=0 RFS=1 RFD=1 RFG=1 typep=-1
mp6 (COb A VDD) CNT_CDF l=0.6 w=5 MU=55 COX=110e-09 COL=0 CGSD=0 COLGSD=0 CSD=0 VTO=-0.7 FLG_SPLT=1 FINGER=1 sdW=10 gsdEnc=1 gcntEnc=3 TEMP=300 LAMBDA=0.005 VSS=0.18 GAMMA=0.35 IOFF=0 MM=1.65 AA=1 SLOPE=10 VAA=1 RCS=500 RCD=500 FLG_FLD=0 RFS=1 RFD=1 RFG=1 typep=-1
mp4 (Sb B n0) CNT_CDF l=0.6 w=5 MU=55 COX=110e-09 COL=0 CGSD=0 COLGSD=0 CSD=0 VTO=-0.7 FLG_SPLT=1 FINGER=1 sdW=10 gsdEnc=1 gcntEnc=3 TEMP=300 LAMBDA=0.005 VSS=0.18 GAMMA=0.35 IOFF=0 MM=1.65 AA=1 SLOPE=10 VAA=1 RCS=500 RCD=500 FLG_FLD=0 RFS=1 RFD=1 RFG=1 typep=-1
mp3 (Sb n1 n3) CNT_CDF l=0.6 w=5 MU=55 COX=110e-09 COL=0 CGSD=0 COLGSD=0 CSD=0 VTO=-0.7 FLG_SPLT=1 FINGER=1 sdW=10 gsdEnc=1 gcntEnc=3 TEMP=300 LAMBDA=0.005 VSS=0.18 GAMMA=0.35 IOFF=0 MM=1.65 AA=1 SLOPE=10 VAA=1 RCS=500 RCD=500 FLG_FLD=0 RFS=1 RFD=1 RFG=1 typep=-1
mn4 (n0 n1 Sb) CNT_CDF_N l=0.6 w=5 MU=55 COX=110e-09 COL=0 CGSD=0 COLGSD=0 CSD=0 VTO=0.7 FLG_SPLT=1 FINGER=1 sdW=10 gsdEnc=1 gcntEnc=3 TEMP=300 LAMBDA=0.005 VSS=0.18 GAMMA=0.35 IOFF=0 MM=1.65 AA=1 SLOPE=10 VAA=1 RCS=500 RCD=500 FLG_FLD=0 RFS=1 RFD=1 RFG=1 typep=1
mn3 (n2 B Sb) CNT_CDF_N l=0.6 w=5 MU=55 COX=110e-09 COL=0 CGSD=0 COLGSD=0 CSD=0 VTO=0.7 FLG_SPLT=1 FINGER=1 sdW=10 gsdEnc=1 gcntEnc=3 TEMP=300 LAMBDA=0.005 VSS=0.18 GAMMA=0.35 IOFF=0 MM=1.65 AA=1 SLOPE=10 VAA=1 RCS=500 RCD=500 FLG_FLD=0 RFS=1 RFD=1 RFG=1 typep=1
mn7 (n4 B COb) CNT_CDF_N l=0.6 w=5 MU=55 COX=110e-09 COL=0 CGSD=0 COLGSD=0 CSD=0 VTO=0.7 FLG_SPLT=1 FINGER=1 sdW=10 gsdEnc=1 gcntEnc=3 TEMP=300 LAMBDA=0.005 VSS=0.18 GAMMA=0.35 IOFF=0 MM=1.65 AA=1 SLOPE=10 VAA=1 RCS=500 RCD=500 FLG_FLD=0 RFS=1 RFD=1 RFG=1 typep=1
mn8 (VSS COb CO) CNT_CDF_N l=0.6 w=5 MU=55 COX=110e-09 COL=0 CGSD=0 COLGSD=0 CSD=0 VTO=0.7 FLG_SPLT=1 FINGER=1 sdW=10 gsdEnc=1 gcntEnc=3 TEMP=300 LAMBDA=0.005 VSS=0.18 GAMMA=0.35 IOFF=0 MM=1.65 AA=1 SLOPE=10 VAA=1 RCS=500 RCD=500 FLG_FLD=0 RFS=1 RFD=1 RFG=1 typep=1
mn5 (VSS Sb S) CNT_CDF_N l=0.6 w=5 MU=55 COX=110e-09 COL=0 CGSD=0 COLGSD=0 CSD=0 VTO=0.7 FLG_SPLT=1 FINGER=1 sdW=10 gsdEnc=1 gcntEnc=3 TEMP=300 LAMBDA=0.005 VSS=0.18 GAMMA=0.35 IOFF=0 MM=1.65 AA=1 SLOPE=10 VAA=1 RCS=500 RCD=500 FLG_FLD=0 RFS=1 RFD=1 RFG=1 typep=1
mn1 (VSS B n1) CNT_CDF_N l=0.6 w=5 MU=55 COX=110e-09 COL=0 CGSD=0 COLGSD=0 CSD=0 VTO=0.7 FLG_SPLT=1 FINGER=1 sdW=10 gsdEnc=1 gcntEnc=3 TEMP=300 LAMBDA=0.005 VSS=0.18 GAMMA=0.35 IOFF=0 MM=1.65 AA=1 SLOPE=10 VAA=1 RCS=500 RCD=500 FLG_FLD=0 RFS=1 RFD=1 RFG=1 typep=1
mn0 (VSS A n0) CNT_CDF_N l=0.6 w=5 MU=55 COX=110e-09 COL=0 CGSD=0 COLGSD=0 CSD=0 VTO=0.7 FLG_SPLT=1 FINGER=1 sdW=10 gsdEnc=1 gcntEnc=3 TEMP=300 LAMBDA=0.005 VSS=0.18 GAMMA=0.35 IOFF=0 MM=1.65 AA=1 SLOPE=10 VAA=1 RCS=500 RCD=500 FLG_FLD=0 RFS=1 RFD=1 RFG=1 typep=1
mn2 (VSS n0 n2) CNT_CDF_N l=0.6 w=5 MU=55 COX=110e-09 COL=0 CGSD=0 COLGSD=0 CSD=0 VTO=0.7 FLG_SPLT=1 FINGER=1 sdW=10 gsdEnc=1 gcntEnc=3 TEMP=300 LAMBDA=0.005 VSS=0.18 GAMMA=0.35 IOFF=0 MM=1.65 AA=1 SLOPE=10 VAA=1 RCS=500 RCD=500 FLG_FLD=0 RFS=1 RFD=1 RFG=1 typep=1
mn6 (VSS A n4) CNT_CDF_N l=0.6 w=5 MU=55 COX=110e-09 COL=0 CGSD=0 COLGSD=0 CSD=0 VTO=0.7 FLG_SPLT=1 FINGER=1 sdW=10 gsdEnc=1 gcntEnc=3 TEMP=300 LAMBDA=0.005 VSS=0.18 GAMMA=0.35 IOFF=0 MM=1.65 AA=1 SLOPE=10 VAA=1 RCS=500 RCD=500 FLG_FLD=0 RFS=1 RFD=1 RFG=1 typep=1
ends ADDHX1
