// Design: CNT_CMOS/AOI22X1
simulator lang=spectre
//global 0 VDD VSS
//include "/simulation/tianliang/test/gpdk045_v_6_0/gpdk045/../models/spectre/gpdk045.scs" section=mc

// CNT_CMOS/AOI22X1/schematic
subckt AOI22X1 VSS VDD A0 A1 B0 B1 Y
mp0 (net18 A0 VDD) CNT_CDF l=0.6 w=5 MU=55 COX=110e-09 COL=0 CGSD=0 COLGSD=0 CSD=0 VTO=-0.7 FLG_SPLT=1 FINGER=1 sdW=10 gsdEnc=1 gcntEnc=3 TEMP=300 LAMBDA=0.005 VSS=0.18 GAMMA=0.35 IOFF=0 MM=1.65 AA=1 SLOPE=10 VAA=1 RCS=500 RCD=500 FLG_FLD=0 RFS=1 RFD=1 RFG=1 typep=-1
mp1 (net18 A1 VDD) CNT_CDF l=0.6 w=5 MU=55 COX=110e-09 COL=0 CGSD=0 COLGSD=0 CSD=0 VTO=-0.7 FLG_SPLT=1 FINGER=1 sdW=10 gsdEnc=1 gcntEnc=3 TEMP=300 LAMBDA=0.005 VSS=0.18 GAMMA=0.35 IOFF=0 MM=1.65 AA=1 SLOPE=10 VAA=1 RCS=500 RCD=500 FLG_FLD=0 RFS=1 RFD=1 RFG=1 typep=-1
mp3 (Y B1 net18) CNT_CDF l=0.6 w=5 MU=55 COX=110e-09 COL=0 CGSD=0 COLGSD=0 CSD=0 VTO=-0.7 FLG_SPLT=1 FINGER=1 sdW=10 gsdEnc=1 gcntEnc=3 TEMP=300 LAMBDA=0.005 VSS=0.18 GAMMA=0.35 IOFF=0 MM=1.65 AA=1 SLOPE=10 VAA=1 RCS=500 RCD=500 FLG_FLD=0 RFS=1 RFD=1 RFG=1 typep=-1
mp2 (Y B0 net18) CNT_CDF l=0.6 w=5 MU=55 COX=110e-09 COL=0 CGSD=0 COLGSD=0 CSD=0 VTO=-0.7 FLG_SPLT=1 FINGER=1 sdW=10 gsdEnc=1 gcntEnc=3 TEMP=300 LAMBDA=0.005 VSS=0.18 GAMMA=0.35 IOFF=0 MM=1.65 AA=1 SLOPE=10 VAA=1 RCS=500 RCD=500 FLG_FLD=0 RFS=1 RFD=1 RFG=1 typep=-1
mn3 (net39 B1 Y) CNT_CDF_N l=0.6 w=5 MU=55 COX=110e-09 COL=0 CGSD=0 COLGSD=0 CSD=0 VTO=0.7 FLG_SPLT=1 FINGER=1 sdW=10 gsdEnc=1 gcntEnc=3 TEMP=300 LAMBDA=0.005 VSS=0.18 GAMMA=0.35 IOFF=0 MM=1.65 AA=1 SLOPE=10 VAA=1 RCS=500 RCD=500 FLG_FLD=0 RFS=1 RFD=1 RFG=1 typep=1
mn1 (net1 A1 Y) CNT_CDF_N l=0.6 w=5 MU=55 COX=110e-09 COL=0 CGSD=0 COLGSD=0 CSD=0 VTO=0.7 FLG_SPLT=1 FINGER=1 sdW=10 gsdEnc=1 gcntEnc=3 TEMP=300 LAMBDA=0.005 VSS=0.18 GAMMA=0.35 IOFF=0 MM=1.65 AA=1 SLOPE=10 VAA=1 RCS=500 RCD=500 FLG_FLD=0 RFS=1 RFD=1 RFG=1 typep=1
mn0 (VSS A0 net1) CNT_CDF_N l=0.6 w=5 MU=55 COX=110e-09 COL=0 CGSD=0 COLGSD=0 CSD=0 VTO=0.7 FLG_SPLT=1 FINGER=1 sdW=10 gsdEnc=1 gcntEnc=3 TEMP=300 LAMBDA=0.005 VSS=0.18 GAMMA=0.35 IOFF=0 MM=1.65 AA=1 SLOPE=10 VAA=1 RCS=500 RCD=500 FLG_FLD=0 RFS=1 RFD=1 RFG=1 typep=1
mn2 (VSS B0 net39) CNT_CDF_N l=0.6 w=5 MU=55 COX=110e-09 COL=0 CGSD=0 COLGSD=0 CSD=0 VTO=0.7 FLG_SPLT=1 FINGER=1 sdW=10 gsdEnc=1 gcntEnc=3 TEMP=300 LAMBDA=0.005 VSS=0.18 GAMMA=0.35 IOFF=0 MM=1.65 AA=1 SLOPE=10 VAA=1 RCS=500 RCD=500 FLG_FLD=0 RFS=1 RFD=1 RFG=1 typep=1
ends AOI22X1
